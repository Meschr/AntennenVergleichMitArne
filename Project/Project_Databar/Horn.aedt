# Ansys Electronics Desktop project, version 2026.1
project variables:
  $a = 7.112mm
  $b = 3.556mm
  $l = 31.5mm
  $w = 1mm
  $A_h = 68.5mm
  $B_h = 56.5mm
  $L_h = 150mm
materials:
  vacuum: permittivity=1
  pec: conductivity=1e+30

design HFSSDesign1 (HFSS, HFSS Modal Network, model units mm)
geometry:
  Box1 = box(corner=(-$a/2, -$b/2, 0mm), size=($a, $b, -$l))
  Box2 [pec] = box(corner=(-$a/2-$w, -$b/2-$w, 0mm), size=($a+2*$w, $b+2*$w, -$l))
  Box2.subtract(Box1)
  Rectangle1 = rectangle(corner=(-$a/2, -$b/2, -$l), x_size=$a, y_size=$b)
  Box3 [pec] = box(corner=(-$a/2-$w, -$b/2-$w, -$l), size=($a+2*$w, $b+2*$w, $w))
  Rectangle3 = rectangle(corner=(-$A_h/2-$w, -$B_h/2-$w, $L_h), x_size=$A_h+2*$w, y_size=$B_h+2*$w)
  big_Horn [vacuum] = rectangle(corner=(-$a/2-$w, $b/2+$w, 0mm), x_size=$a+2*$w, y_size=-$b-2*$w)
  big_Horn.connect(Rectangle3)
  Rectangle5 = rectangle(corner=(-$A_h/2, -$B_h/2, $L_h), x_size=$A_h, y_size=$B_h)
  small_Horn = rectangle(corner=(-$a/2, -$b/2, 0mm), x_size=$a, y_size=$b)
  small_Horn.connect(Rectangle5)
  big_Horn.subtract(small_Horn)
boundaries and excitations:
  Port1: Wave Port Faces=Rectangle1.face WavePortType=Default NumModes=1 Modes{Mode1{IntLine{(0, -1.778, -31.5) -> (0, 1.778, -31.5)} CharImp=Zpi}}
source amplitudes:
  Port1:1: 1W 0deg
