# Ansys Electronics Desktop project, version 2025.2
project variables:
  $a = 7.112mm
  $b = 3.556mm
  $l = 31.5mm
  $w = 1mm
  $A_h = 68.5mm
  $B_h = 56.5mm
  $L_h = 150mm
  $lambda_1 = 11.31mm
  $lambda_2 = 7.475mm
materials:
  vacuum: permittivity=1
  pec: conductivity=1e+30

design HFSSDesign1 (HFSS, HFSS Modal Network, model units mm)
geometry:
  Box1 = box(corner=(-$a/2, -$b/2, 0mm), size=($a, $b, -$l))
  Waveguide = box(corner=(-$a/2-$w, -$b/2-$w, 0mm), size=($a+2*$w, $b+2*$w, -$l))
  Waveguide.subtract(Box1)
  Rectangle1 = rectangle(corner=(-$a/2, -$b/2, -$l), x_size=$a, y_size=$b)
  Cap = box(corner=(-$a/2-$w, -$b/2-$w, -$l-$w), size=($a+2*$w, $b+2*$w, $w))
  Rectangle3 = rectangle(corner=(-$A_h/2-$w, -$B_h/2-$w, $L_h), x_size=$A_h+2*$w, y_size=$B_h+2*$w)
  big_Horn [pec] = rectangle(corner=(-$a/2-$w, $b/2+$w, 0mm), x_size=$a+2*$w, y_size=-$b-2*$w)
  big_Horn.connect(Rectangle3)
  Rectangle5 = rectangle(corner=(-$A_h/2, -$B_h/2, $L_h), x_size=$A_h, y_size=$B_h)
  small_Horn = rectangle(corner=(-$a/2, -$b/2, 0mm), x_size=$a, y_size=$b)
  small_Horn.connect(Rectangle5)
  big_Horn.subtract(small_Horn)
  big_Horn.unite(Cap, Waveguide)
  Airbox [vacuum] = box(corner=(-($A_h+2*$w+$lambda_1)/2, -($B_h+2*$w+$lambda_1)/2, -$l-$w-$lambda_1/2), size=($A_h+2*$w+$lambda_1, $B_h+2*$w+$lambda_1, $l+$w+$lambda_1/2+$L_h+$lambda_1/2))
boundaries and excitations:
  Rad1: Radiation Objects=Airbox
  Port1: Wave Port Faces=Rectangle1.face WavePortType=Modal NumModes=1 Modes{Mode1{IntLine{(0, -1.778, -31.5) -> (0, 1.778, -31.5)} CharImp=Zpi}}
setups:
  Setup1: HfssDriven Frequency=33.25GHz MaxDeltaS=0.02 MaximumPasses=6 MinimumPasses=1 MinimumConvergedPasses=1 PercentRefinement=30 disabled BasisOrder=1 PortAccuracy=2 DrivenSolverType="Iterative Solver" IterativeResidual=1e-06 DDMSolverResidual=0.0001
    sweep Sweep: 26.5GHz to 40GHz step 0.1GHz; Type=Interpolating InterpTolerance=0.5 InterpMaxSolns=250 InterpUsePortImped=false PassivityErrorTolerance=0.0001
  Setup2_lowF: HfssDriven Frequency=26.5GHz MaxDeltaS=0.02 MaximumPasses=6 MinimumPasses=1 MinimumConvergedPasses=1 PercentRefinement=30 disabled BasisOrder=1 PortAccuracy=2 DrivenSolverType="Auto Select Direct/Iterative"
    sweep Sweep: 26GHz to 39.75GHz, 401 points; Type=Interpolating InterpTolerance=0.5 InterpMaxSolns=250 InterpUsePortImped=false PassivityErrorTolerance=0.0001
  Setup3_highF: HfssDriven Frequency=40GHz MaxDeltaS=0.02 MaximumPasses=6 MinimumPasses=1 MinimumConvergedPasses=1 PercentRefinement=30 BasisOrder=1 PortAccuracy=2 DrivenSolverType="Auto Select Direct/Iterative"
    sweep Sweep: 26GHz to 41GHz, 401 points; Type=Interpolating InterpTolerance=0.5 InterpMaxSolns=250 InterpUsePortImped=false PassivityErrorTolerance=0.0001
source amplitudes:
  Port1:1: 1W 0deg
radiation setups:
  Infinite Sphere1: Infinite Sphere Theta=-180deg..180deg step 1deg Phi=0deg..180deg step 1deg
reports:
  Directivity_3D_33_25: dB(DirTotal) vs Phi, Theta on Setup1 : LastAdaptive, Infinite Sphere1 [Freq=33.25GHz]
  Directivity_2D_33_25: dB(DirTotal) vs Theta on Setup1 : LastAdaptive, Infinite Sphere1 [Phi=all Freq=33.25GHz]
  Directivity_2D_26_5: dB(DirTotal) vs Theta on Setup2_lowF : LastAdaptive, Infinite Sphere1 [Phi=all Freq=26.5GHz]
  Directivity_3D_26_5: dB(DirTotal) vs Phi, Theta on Setup2_lowF : LastAdaptive, Infinite Sphere1 [Freq=26.5GHz]
  Directivity_3D_40: dB(DirTotal) vs Phi, Theta on Setup3_highF : LastAdaptive, Infinite Sphere1 [Freq=40GHz]
  Directivity_2D_40: dB(DirTotal) vs Theta on Setup3_highF : LastAdaptive, Infinite Sphere1 [Phi=all Freq=40GHz]; markers m1 at 0deg
  Directivity_Ka_2D_DirTheta: dB(DirTheta) vs Theta on Setup1 : LastAdaptive, Infinite Sphere1 [Phi=all Freq=33.25GHz]
