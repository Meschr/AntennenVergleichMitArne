# Ansys Electronics Desktop project, version 2025.2
project variables:
  $a = 47.55mm
  $b = 22.2mm
  $l = 68mm
  $w = 8.4mm
  $A_h = 216mm
  $B_h = 160mm
  $L_h = 240mm
  $lambda_1 = ((c0/3.95E9)*1000) mm
  $lambda_2 = 7.475mm
materials:
  vacuum: permittivity=1
  pec: conductivity=1e+30

design HFSSDesign1 (HFSS, HFSS Modal Network, model units mm)
geometry:
  Box1 = box(corner=(-$a/2, -$b/2, 0mm), size=($a, $b, -$l))
  Waveguide = box(corner=(-$a/2-$w, -$b/2-$w, 0mm), size=($a+2*$w, $b+2*$w, -$l))
  Waveguide.subtract(Box1)
  Rectangle1 = rectangle(corner=(-$a/2, -$b/2, -$l), x_size=$a, y_size=$b)
  Cap = box(corner=(-$a/2-$w, -$b/2-$w, -$l-$w), size=($a+2*$w, $b+2*$w, $w))
  Rectangle3 = rectangle(corner=(-$A_h/2-$w, -$B_h/2-$w, $L_h), x_size=$A_h+2*$w, y_size=$B_h+2*$w)
  big_Horn [pec] = rectangle(corner=(-$a/2-$w, $b/2+$w, 0mm), x_size=$a+2*$w, y_size=-$b-2*$w)
  big_Horn.connect(Rectangle3)
  Rectangle5 = rectangle(corner=(-$A_h/2, -$B_h/2, $L_h), x_size=$A_h, y_size=$B_h)
  small_Horn = rectangle(corner=(-$a/2, -$b/2, 0mm), x_size=$a, y_size=$b)
  small_Horn.connect(Rectangle5)
  big_Horn.subtract(small_Horn)
  big_Horn.unite(Cap, Waveguide)
  Airbox [vacuum] = box(corner=(-($A_h+2*$w+$lambda_1)/2, -($B_h+2*$w+$lambda_1)/2, -$l-$w-$lambda_1/2), size=($A_h+2*$w+$lambda_1, $B_h+2*$w+$lambda_1, $l+$w+$lambda_1/2+$L_h+$lambda_1/2))
boundaries and excitations:
  Rad1: Radiation Objects=Airbox
  Port1: Wave Port Faces=Rectangle1.face WavePortType=Modal NumModes=1 Modes{Mode1{IntLine{(0, -11.1, -68) -> (0, 11.1, -68)} CharImp=Zpi}}
setups:
  MiddleF: HfssDriven Frequency=4.9GHz MaxDeltaS=0.02 MaximumPasses=6 MinimumPasses=1 MinimumConvergedPasses=1 PercentRefinement=30 disabled BasisOrder=1 PortAccuracy=2 DrivenSolverType="Auto Select Direct/Iterative"
    sweep Sweep: 3GHz to 6GHz step 0.1GHz; Type=Interpolating InterpTolerance=0.5 InterpMaxSolns=250 InterpUsePortImped=false PassivityErrorTolerance=0.0001
  LowF: HfssDriven Frequency=3.95GHz MaxDeltaS=0.02 MaximumPasses=6 MinimumPasses=1 MinimumConvergedPasses=1 PercentRefinement=30 BasisOrder=1 PortAccuracy=2 DrivenSolverType="Auto Select Direct/Iterative"
    sweep Sweep: 3GHz to 6GHz step 0.1GHz; Type=Interpolating InterpTolerance=0.5 InterpMaxSolns=250 InterpUsePortImped=false PassivityErrorTolerance=0.0001
  HighF: HfssDriven Frequency=5.85GHz MaxDeltaS=0.02 MaximumPasses=6 MinimumPasses=1 MinimumConvergedPasses=1 PercentRefinement=30 BasisOrder=1 PortAccuracy=2 DrivenSolverType="Auto Select Direct/Iterative"
    sweep Sweep: 3GHz to 6GHz step 0.1GHz; Type=Interpolating InterpTolerance=0.5 InterpMaxSolns=250 InterpUsePortImped=false PassivityErrorTolerance=0.0001
source amplitudes:
  Port1:1: 1W 0deg
radiation setups:
  Infinite Sphere1: Infinite Sphere Theta=-180deg..180deg step 1deg Phi=0deg..180deg step 1deg
reports:
  Directivity_C_3D_4_9: dB(DirTotal) vs Phi, Theta on MiddleF : LastAdaptive, Infinite Sphere1 [Freq=4.9GHz]
  Directivity_C_2D_3_95: dB(DirTotal) vs Theta on LowF : LastAdaptive, Infinite Sphere1 [Phi=all Freq=3.95GHz]
  Directivity_C_2D_5_85: dB(DirTotal) vs Theta on HighF : LastAdaptive, Infinite Sphere1 [Phi=all Freq=5.85GHz]
  Directivity_C_3D_3_95: dB(DirTotal) vs Phi, Theta on LowF : LastAdaptive, Infinite Sphere1 [Freq=3.95GHz]
  Directivity_C_3D_5_85: dB(DirTotal) vs Phi, Theta on HighF : LastAdaptive, Infinite Sphere1 [Freq=5.85GHz]
  Directivity_C_2D_4_9: dB(DirTotal) vs Theta on MiddleF : LastAdaptive, Infinite Sphere1 [Phi=all Freq=4.9GHz]
  Directivity Plot1: dB(DirTotal) vs Theta on MiddleF : LastAdaptive, Infinite Sphere1 [Phi=all Freq=4.9GHz]
